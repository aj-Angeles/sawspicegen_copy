.title SPICE Blocks of SAW Device

.SUBCKT DLINE Vip Vim Vop Vom
R1 1 0 62216622.72617687
X1 Vip Vim 1 2 IDT
X2 2 3 SENSE
X3 Vop Vom 3 4 IDT
R2 4 0 62216622.72617687
C1 Vip Vop {Cf}
.ENDS

.SUBCKT IDT Vp Vm 1 41
X1 Vp Vm 1 2 FING
X2 Vp Vm 2 3 FING
X3 Vp Vm 3 4 FING
X4 Vp Vm 4 5 FING
X5 Vp Vm 5 6 FING
X6 Vp Vm 6 7 FING
X7 Vp Vm 7 8 FING
X8 Vp Vm 8 9 FING
X9 Vp Vm 9 10 FING
X10 Vp Vm 10 11 FING
X11 Vp Vm 11 12 FING
X12 Vp Vm 12 13 FING
X13 Vp Vm 13 14 FING
X14 Vp Vm 14 15 FING
X15 Vp Vm 15 16 FING
X16 Vp Vm 16 17 FING
X17 Vp Vm 17 18 FING
X18 Vp Vm 18 19 FING
X19 Vp Vm 19 20 FING
X20 Vp Vm 20 21 FING
X21 Vp Vm 21 22 FING
X22 Vp Vm 22 23 FING
X23 Vp Vm 23 24 FING
X24 Vp Vm 24 25 FING
X25 Vp Vm 25 26 FING
X26 Vp Vm 26 27 FING
X27 Vp Vm 27 28 FING
X28 Vp Vm 28 29 FING
X29 Vp Vm 29 30 FING
X30 Vp Vm 30 31 FING
X31 Vp Vm 31 32 FING
X32 Vp Vm 32 33 FING
X33 Vp Vm 33 34 FING
X34 Vp Vm 34 35 FING
X35 Vp Vm 35 36 FING
X36 Vp Vm 36 37 FING
X37 Vp Vm 37 38 FING
X38 Vp Vm 38 39 FING
X39 Vp Vm 39 40 FING
X40 Vp Vm 40 41 FING
.ENDS

.SUBCKT FING Vp Vm 1 5
T1 1 2 3 2 Z0=62216622.72617687 td=2.857142857142857e-09
T2 3 4 5 4 Z0=62216622.72617687 td=2.857142857142857e-09
C1 2 0 2.296125e-15
R1 2 Vp 800.0
C2 4 0 2.296125e-15
R2 4 Vm 800.0
.ENDS

.param k1={10**(-Ap/20)}
.param k2={(5/k1+sqrt(25/(k1**2)-16))/2}
.SUBCKT SENSE 1 5
T1 1 0 2 0 Z0=62216622.72617687 td={2.8869999999999996e-09+tp}
R1 2 0 62216622.72617687
F1 0 2 V1 {k2}
V1 3 0 0
E1 4 3 2 0 {k2}
R2 4 5 62216622.72617687
.ENDS
