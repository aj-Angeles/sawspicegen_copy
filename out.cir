.title SPICE Blocks of SAW Device

.SUBCKT DLINE Vip Vim Vop Vom
R1 1 0 10000000.000000002
X1 Vip Vim 1 2 IDT
X2 2 3 SENSE
X3 Vop Vom 3 4 IDT
R2 4 0 10000000.000000002
C1 Vip Vop {Cf}
.ENDS

.SUBCKT IDT Vp Vm 1 11
X1 Vp Vm 1 2 FING
X2 Vp Vm 2 3 FING
X3 Vp Vm 3 4 FING
X4 Vp Vm 4 5 FING
X5 Vp Vm 5 6 FING
X6 Vp Vm 6 7 FING
X7 Vp Vm 7 8 FING
X8 Vp Vm 8 9 FING
X9 Vp Vm 9 10 FING
X10 Vp Vm 10 11 FING
.ENDS

.SUBCKT FING Vp Vm 1 5
T1 1 2 3 2 Z0=10000000.000000002 td=5e-09
T2 3 4 5 4 Z0=10000000.000000002 td=5e-09
C1 2 0 2.5e-14
R1 2 Vp 50.0
C2 4 0 2.5e-14
R2 4 Vm 50.0
.ENDS

.param k1={10**(-Ap/20)}
.param k2={(5/k1+sqrt(25/(k1**2)-16))/2}
.SUBCKT SENSE 1 5
T1 1 0 2 0 Z0=10000000.000000002 td={1e-06+tp}
R1 2 0 10000000.000000002
F1 0 2 V1 {k2}
V1 3 0 0
E1 4 3 2 0 {k2}
R2 4 5 10000000.000000002
.ENDS
