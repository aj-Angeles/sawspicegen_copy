.title SPICE Blocks of SAW Device

.SUBCKT DLINE Vip Vim Vop Vom
R1 1 0 10000000.000000002
X1 Vip Vim 1 2 IDT
X2 2 3 SENSE
X3 Vop Vom 3 4 IDT
R2 4 0 10000000.000000002
C1 Vip Vop {Cf}
.ENDS

.SUBCKT IDT Vp Vm 1 11
X1 Vp Vm 1 2 FING
X2 Vp Vm 2 3 FING
X3 Vp Vm 3 4 FING
X4 Vp Vm 4 5 FING
X5 Vp Vm 5 6 FING
X6 Vp Vm 6 7 FING
X7 Vp Vm 7 8 FING
X8 Vp Vm 8 9 FING
X9 Vp Vm 9 10 FING
X10 Vp Vm 10 11 FING
.ENDS

.SUBCKT FING Vp Vm 1 7
X1 1 2 TAN
X2 2 3 CSC
X3 2 4 TAN
C1 3 0 2.5e-14
R1 3 Vp 50.0
X4 4 5 TAN
X5 5 6 CSC
X6 5 7 TAN
C2 6 0 2.5e-14
R2 6 Vm 50.0
.ENDS

.param k1={10**(-Ap/20)}
.param k2={(5/k1+sqrt(25/(k1**2)-16))/2}
.SUBCKT SENSE 1 5
T1 1 0 2 0 Z0=10000000.000000002 td={1e-06+tp}
R1 2 0 10000000.000000002
F1 0 2 V1 {k2}
V1 3 0 0
E1 4 3 2 0 {k2}
R2 4 5 10000000.000000002
.ENDS

.SUBCKT TAN 1 4
C1 1 2 1.2346565282280364e-16
L1 1 2 0.020516066882939638
C2 2 3 1.0582770241954598e-16
L2 2 3 0.0026594901514921756
C3 3 4 5.879316801085888e-17
L3 3 4 0.0017233496181669299
.ENDS

.SUBCKT CSC 1 8
C1 1 2 -2.469313056456073e-16
L1 1 2 -0.010258033441469819
C2 2 3 -2.1165540483909196e-16
L2 2 3 -0.0013297450757460878
C3 3 4 -1.1758633602171775e-16
L3 3 4 -0.0008616748090834649
C4 4 5 5.014604976187718e-16
C5 5 6 2.387907131517961e-16
L5 5 6 0.002651934781743618
C6 6 7 1.9899226095983006e-16
L6 6 7 0.0007955804345230855
C7 7 8 1.0854123325081638e-16
L7 7 8 0.0006482507244262179
.ENDS
