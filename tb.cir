.title SPICE Testbench of SAW Device
.include out.cir
.param Ap=0
.param tp=0
.param Cf=10f
V1 Vi 0 AC 1 PULSE(0 5 0 1n 1n 10n) DC 0
R1 Vi Di 50
X1 Di 0 Dop Dom DLINE
R2 Dop Dom 50

.AC LIN 10000 1750000.0 350000000.0
*.TRAN 1N 1.4434999999999998e-08 uic
